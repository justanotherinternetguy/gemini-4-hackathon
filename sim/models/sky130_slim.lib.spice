* Slim SKY130 lib: nfet_01v8 + pfet_01v8 only, generated from ciel sky130A combined/continuous
.lib tt
.param MC_MM_SWITCH=0
.param MC_PR_SWITCH=0
.param corner_factor=1
.param process_mc_factor=1
.param mismatch_factor=1
.include /home/thinkies/.ciel/sky130A/libs.tech/combined/continuous/parameters_fet_tt.spice
.include /home/thinkies/.ciel/sky130A/libs.tech/combined/continuous/parameters_res_nom.spice
.include /home/thinkies/.ciel/sky130A/libs.tech/combined/continuous/parameters_cap_nom.spice
.include /home/thinkies/.ciel/sky130A/libs.tech/combined/continuous/models_global.spice
.include /home/thinkies/.ciel/sky130A/libs.tech/combined/continuous/models_fet/sky130_fd_pr__nfet_01v8.spice
.include /home/thinkies/.ciel/sky130A/libs.tech/combined/continuous/models_fet/sky130_fd_pr__pfet_01v8.spice
.include /home/thinkies/.ciel/sky130A/libs.tech/combined/continuous/models_fet/sky130_fd_pr__nfet_01v8_lvt.spice
.include /home/thinkies/.ciel/sky130A/libs.tech/combined/continuous/models_fet/sky130_fd_pr__pfet_01v8_lvt.spice
.endl tt
.lib ff
.param MC_MM_SWITCH=0
.param MC_PR_SWITCH=0
.param corner_factor=1
.param process_mc_factor=1
.param mismatch_factor=1
.include /home/thinkies/.ciel/sky130A/libs.tech/combined/continuous/parameters_fet_ff.spice
.include /home/thinkies/.ciel/sky130A/libs.tech/combined/continuous/parameters_res_nom.spice
.include /home/thinkies/.ciel/sky130A/libs.tech/combined/continuous/parameters_cap_nom.spice
.include /home/thinkies/.ciel/sky130A/libs.tech/combined/continuous/models_global.spice
.include /home/thinkies/.ciel/sky130A/libs.tech/combined/continuous/models_fet/sky130_fd_pr__nfet_01v8.spice
.include /home/thinkies/.ciel/sky130A/libs.tech/combined/continuous/models_fet/sky130_fd_pr__pfet_01v8.spice
.include /home/thinkies/.ciel/sky130A/libs.tech/combined/continuous/models_fet/sky130_fd_pr__nfet_01v8_lvt.spice
.include /home/thinkies/.ciel/sky130A/libs.tech/combined/continuous/models_fet/sky130_fd_pr__pfet_01v8_lvt.spice
.endl ff
.lib ss
.param MC_MM_SWITCH=0
.param MC_PR_SWITCH=0
.param corner_factor=1
.param process_mc_factor=1
.param mismatch_factor=1
.include /home/thinkies/.ciel/sky130A/libs.tech/combined/continuous/parameters_fet_ss.spice
.include /home/thinkies/.ciel/sky130A/libs.tech/combined/continuous/parameters_res_nom.spice
.include /home/thinkies/.ciel/sky130A/libs.tech/combined/continuous/parameters_cap_nom.spice
.include /home/thinkies/.ciel/sky130A/libs.tech/combined/continuous/models_global.spice
.include /home/thinkies/.ciel/sky130A/libs.tech/combined/continuous/models_fet/sky130_fd_pr__nfet_01v8.spice
.include /home/thinkies/.ciel/sky130A/libs.tech/combined/continuous/models_fet/sky130_fd_pr__pfet_01v8.spice
.include /home/thinkies/.ciel/sky130A/libs.tech/combined/continuous/models_fet/sky130_fd_pr__nfet_01v8_lvt.spice
.include /home/thinkies/.ciel/sky130A/libs.tech/combined/continuous/models_fet/sky130_fd_pr__pfet_01v8_lvt.spice
.endl ss
.lib sf
.param MC_MM_SWITCH=0
.param MC_PR_SWITCH=0
.param corner_factor=1
.param process_mc_factor=1
.param mismatch_factor=1
.include /home/thinkies/.ciel/sky130A/libs.tech/combined/continuous/parameters_fet_sf.spice
.include /home/thinkies/.ciel/sky130A/libs.tech/combined/continuous/parameters_res_nom.spice
.include /home/thinkies/.ciel/sky130A/libs.tech/combined/continuous/parameters_cap_nom.spice
.include /home/thinkies/.ciel/sky130A/libs.tech/combined/continuous/models_global.spice
.include /home/thinkies/.ciel/sky130A/libs.tech/combined/continuous/models_fet/sky130_fd_pr__nfet_01v8.spice
.include /home/thinkies/.ciel/sky130A/libs.tech/combined/continuous/models_fet/sky130_fd_pr__pfet_01v8.spice
.include /home/thinkies/.ciel/sky130A/libs.tech/combined/continuous/models_fet/sky130_fd_pr__nfet_01v8_lvt.spice
.include /home/thinkies/.ciel/sky130A/libs.tech/combined/continuous/models_fet/sky130_fd_pr__pfet_01v8_lvt.spice
.endl sf
.lib fs
.param MC_MM_SWITCH=0
.param MC_PR_SWITCH=0
.param corner_factor=1
.param process_mc_factor=1
.param mismatch_factor=1
.include /home/thinkies/.ciel/sky130A/libs.tech/combined/continuous/parameters_fet_fs.spice
.include /home/thinkies/.ciel/sky130A/libs.tech/combined/continuous/parameters_res_nom.spice
.include /home/thinkies/.ciel/sky130A/libs.tech/combined/continuous/parameters_cap_nom.spice
.include /home/thinkies/.ciel/sky130A/libs.tech/combined/continuous/models_global.spice
.include /home/thinkies/.ciel/sky130A/libs.tech/combined/continuous/models_fet/sky130_fd_pr__nfet_01v8.spice
.include /home/thinkies/.ciel/sky130A/libs.tech/combined/continuous/models_fet/sky130_fd_pr__pfet_01v8.spice
.include /home/thinkies/.ciel/sky130A/libs.tech/combined/continuous/models_fet/sky130_fd_pr__nfet_01v8_lvt.spice
.include /home/thinkies/.ciel/sky130A/libs.tech/combined/continuous/models_fet/sky130_fd_pr__pfet_01v8_lvt.spice
.endl fs
